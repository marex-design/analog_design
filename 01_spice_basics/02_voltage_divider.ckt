Voltage Divider - Week 1 Day 1 - Exercise 2

V1 vin 0 DC 12
R1 vin vout 2k
R2 vout 0 1k

.op

.print op v(vin) v(vout) i(v1)

.end
