Voltage divider  - Week 1 day 1

V1 vin 0 DC 12V
R1 vin vout 2k
R2 vout 0 1k

.op

.print op v(vin) v(vout) i(v1)

.end
