Series Network with Measurements

V1 vin 0 DC 12
R1 vin n1 1k
R2 n1 n2 2k
R3 n2 0 3k

.dc V1 0 12 1

.print dc v(vin) v(n1) v(n2) i(v1)

.meas dc vin_at_12 FIND v(vin) AT=12
.meas dc n1_at_12 FIND v(n1) AT=12
.meas dc n2_at_12 FIND v(n2) AT=12
.meas dc current_at_12 FIND i(v1) AT=12

.end
